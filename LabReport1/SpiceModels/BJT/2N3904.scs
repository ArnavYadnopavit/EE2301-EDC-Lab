simulator lang=spice
.MODEL 2N3904 NPN(IS=4.639E-15 NF=0.9995 ISE=2.091E-14 NE=1.6 BF=160.1 IKF=0.12
+                 VAF=98.69 NR=1.001 ISC=3.257E-12 NC=1.394 BR=5.944 IKR=0.06
+                 VAR=19.29 RB=1 IRB=1E-6 RBM=1 RE=0.3614 RC=1.755 XTB=0
+                 EG=1.11 XTI=3 CJE=5.631E-12 VJE=0.7002 MJE=0.3385
+                 TF=3.001E-10 XTF=27 VTF=1.461 ITF=0.2723 PTF=0 CJC=4.949E-12
+                 VJC=0.5969 MJC=0.1928 XCJC=0.864 TR=9.4E-8 CJS=0 VJS=0.75
+                 MJS=0.333 FC=0.5582)
simulator lang=spectre
