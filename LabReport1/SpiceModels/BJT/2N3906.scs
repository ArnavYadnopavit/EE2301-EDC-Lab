simulator lang=spice
.model 2N3906 PNP (
+ Is=1.41f
+ Xti=3
+ Eg=1.11
+ Vaf=18.7
+ Bf=180.7
+ Ne=1.5
+ Ise=0
+ Ikf=80m
+ Xtb=1.5
+ Br=4.977
+ Nc=2
+ Isc=0
+ Ikr=0
+ Rc=2.5
+ Cjc=9.728p
+ Mjc=.5776
+ Vjc=.75
+ Fc=.5
+ Cje=8.063p
+ Mje=.3677
+ Vje=.75
+ Tr=33.42n
+ Tf=179.3p
+ Itf=.4
+ Vtf=4
+ Xtf=6
+ Rb=10)
simulator lang=spectre
