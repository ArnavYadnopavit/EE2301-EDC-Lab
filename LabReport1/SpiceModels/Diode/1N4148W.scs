simulator lang=spice
* 1N4148W Diode SPICE Model
.MODEL 1N4148W D ( IS=10.4n RS=51.5m BV=75.0 IBV=1.00u
+ CJO=2.00p M=0.333 N=2.07 TT=5.76n )
simulator lang=spectre
